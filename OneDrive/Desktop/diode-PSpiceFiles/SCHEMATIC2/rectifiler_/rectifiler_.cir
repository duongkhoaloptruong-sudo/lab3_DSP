** Profile: "SCHEMATIC2-rectifiler_"  [ C:\Users\bahuy\OneDrive\Desktop\diode-pspicefiles\schematic2\rectifiler_.sim ]

** Creating circuit file "rectifiler_.cir"
** WARNING: THIS AUTOMATICALLY GENERATED FILE MAY BE OVERWRITTEN BY SUBSEQUENT SIMULATIONS

*Libraries:
* Profile Libraries :
* Local Libraries :
.LIB "../../../diode-PSpiceFiles/PSpiceModelApps/PSpiceModelApps_Include.lib"
* From [PSPICE NETLIST] section of C:\cds_spb_home\cdssetup\OrCAD_PSpiceTIPSpice_Install\23.1.0\PSpice.ini file:
.lib "nom_pspti.lib"
.lib "nom.lib"

*Analysis directives:
.TRAN  0 10ms 0 1ms
.OPTIONS ADVCONV
.OPTIONS FILEMODELSEARCH
.OPTIONS ABSTOL= 0.001
.OPTIONS CHGTOL= 0.001
.OPTIONS GMIN= 1.0E-9
.OPTIONS VNTOL= 0.001
.PROBE64 V(alias(*)) I(alias(*)) W(alias(*)) D(alias(*)) NOISE(alias(*))
.INC "..\SCHEMATIC2.net"

.END
