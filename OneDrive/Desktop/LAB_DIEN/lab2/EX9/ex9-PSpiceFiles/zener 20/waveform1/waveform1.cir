** Profile: "zener 20-waveform1"  [ c:\cds_spb_home\cdssetup\projects\ex9\ex9-PSpiceFiles\zener 20\waveform1.sim ]

** Creating circuit file "waveform1.cir"
** WARNING: THIS AUTOMATICALLY GENERATED FILE MAY BE OVERWRITTEN BY SUBSEQUENT SIMULATIONS

*Libraries:
* Profile Libraries :
* Local Libraries :
.LIB "../../../ex9-PSpiceFiles/PSpiceModelApps/PSpiceModelApps_Include.lib"
* From [PSPICE NETLIST] section of C:\cds_spb_home\cdssetup\OrCAD_PSpiceTIPSpice_Install\23.1.0\PSpice.ini file:
.lib "nom_pspti.lib"
.lib "nom.lib"

*Analysis directives:
.TRAN  0 100ms 0 0.1ms
.OPTIONS ADVCONV
.OPTIONS FILEMODELSEARCH
.PROBE64 V(alias(*)) I(alias(*)) W(alias(*)) D(alias(*)) NOISE(alias(*))
.INC "..\zener 20.net"

.END
