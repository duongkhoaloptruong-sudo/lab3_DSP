** Profile: "R+C-waveform"  [ c:\cds_spb_home\cdssetup\projects\ex10\ex10-PSpiceFiles\R+C\waveform.sim ]

** Creating circuit file "waveform.cir"
** WARNING: THIS AUTOMATICALLY GENERATED FILE MAY BE OVERWRITTEN BY SUBSEQUENT SIMULATIONS

*Libraries:
* Profile Libraries :
* Local Libraries :
.LIB "../../../ex10-PSpiceFiles/PSpiceModelApps/PSpiceModelApps_Include.lib"
* From [PSPICE NETLIST] section of C:\cds_spb_home\cdssetup\OrCAD_PSpiceTIPSpice_Install\23.1.0\PSpice.ini file:
.lib "nom_pspti.lib"
.lib "nom.lib"

*Analysis directives:
.TRAN  0 10ms 0 1ms
.OPTIONS ADVCONV
.OPTIONS FILEMODELSEARCH
.OPTIONS ABSTOL= 0.001
.OPTIONS CHGTOL= 0.001
.OPTIONS GMIN= 1.0E-9
.OPTIONS VNTOL= 0.001
.PROBE64 V(alias(*)) I(alias(*)) W(alias(*)) D(alias(*)) NOISE(alias(*))
.INC "..\R+C.net"

.END
